* Extracted by KLayout with SG13G2 LVS runset on : 12/09/2026 05:48

.SUBCKT InverterBeta
M$1 VSS A Y VSS sg13_lv_nmos L=0.14u W=0.15u AS=0.099p AD=0.1005p PS=1.32u
+ PD=1.34u rfmode=0
M$2 VDD A Y VDD sg13_lv_pmos L=0.14u W=0.15u AS=0.1005p AD=0.099p PS=1.34u
+ PD=1.32u rfmode=0
.ENDS InverterBeta
