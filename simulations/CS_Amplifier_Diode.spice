** sch_path: /foss/designs/BaiTap1/CS_Amplifier_Diode.sch
**.subckt CS_Amplifier_Diode IN VSS OUT VDD
*.ipin IN
*.iopin VSS
*.opin OUT
*.iopin VDD
XM1 OUT IN VSS VSS sg13_lv_nmos w=10u l=0.5u ng=1 m=1 mm_ok=1
C1 OUT VSS 100f
XM2 OUT OUT VDD VDD sg13_lv_pmos w=10u l=1u ng=1 m=1 mm_ok=1
**** begin user architecture code

.lib cornerMOSlv.lib mos_tt

**** end user architecture code
**.ends
.end
