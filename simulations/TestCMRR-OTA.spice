** sch_path: /foss/designs/BTDay7-Ex/TestCMRR-OTA.sch
**.subckt TestCMRR-OTA
I2 net1 GND 80u
Cload vout1 GND 500f
vdd vdd GND DC 1.2
vp vp GND DC 0.6 AC 1 0
x1 vp vp vdd net1 vout1 GND OTA
I1 net2 GND 80u
C2 vm2 GND 4G
L9 vout2 vm2 4G
x2 vm2 net3 VDDac net2 vout2 GND OTA
v4 net3 GND DC 0.6
v2 VDDac GND DC 1.2 AC 1 0
I0 net4 GND 80u
Cload1 vout GND 500f
C1 vm1 GND 4G
L15 vout vm1 4G
x3 vm1 vp vdd net4 vout GND OTA
**** begin user architecture code

.lib /foss/pdks/ihp-sg13g2/libs.tech/ngspice/models/cornerCAP.lib cap_typ
.lib cornerMOSlv.lib mos_tt

.control
op
save all

* Chay phan tich AC tu 1Hz den 10MHz
ac dec 100 1 10e6
save all

* Tinh toan cac dai luong theo Slide 23
let Av = db(v(vout))
let PSRR = db(v(vout2)/v(VDDac))
let CMRR = db((v(vout)/v(vp))/(v(vout1)/v(vp)))
let phase = 180*cph(vout)/pi

* Ghi du lieu ra file raw
write output_file.raw

* Ve do thi kiem tra truc tiep tren Ngspice
plot CMRR xlog title 'Common-Mode Rejection Ratio - CMRR (dB)'
plot PSRR xlog title 'Power Supply Rejection Ratio - PSRR (dB)'
.endc

**** end user architecture code
**.ends

* expanding   symbol:  /foss/designs/BTDay7-Ex/OTA.sym # of pins=6
** sym_path: /foss/designs/BTDay7-Ex/OTA.sym
** sch_path: /foss/designs/BTDay7-Ex/OTA.sch
.subckt OTA v- v+ vdd iout vout vss
*.iopin vdd
*.iopin iout
*.iopin v-
*.iopin vss
*.iopin v+
*.iopin vout
XM6 iout iout vdd vdd sg13_lv_pmos w=75u l=2.08u ng=8 m=1 mm_ok=1
XM7 net1 iout vdd vdd sg13_lv_pmos w=5.3u l=1.95u ng=1 m=1 mm_ok=1
XM8 net3 v- net1 vdd sg13_lv_pmos w=7.41u l=3.64u ng=1 m=1 mm_ok=1
XM9 net2 v+ net1 vdd sg13_lv_pmos w=7.41u l=3.64u ng=1 m=1 mm_ok=1
XM10 net3 net3 vss vss sg13_lv_nmos w=720n l=9.75u ng=1 m=1 mm_ok=1
XM11 net2 net3 vss vss sg13_lv_nmos w=720n l=9.75u ng=1 m=1 mm_ok=1
XM1 vout net2 vss vss sg13_lv_nmos w=28.8u l=9.75u ng=4 m=1 mm_ok=1
XM2 vout iout vdd vdd sg13_lv_pmos w=75u l=2.08u ng=8 m=1 mm_ok=1
XC1 net2 vout cap_cmim w=22.295e-6 l=22.295e-6 m=1 mm_ok=1
.ends

.GLOBAL GND
.end
