** sch_path: /foss/designs/Test_InverterWave.sch
**.subckt Test_InverterWave
XM1 OUT A vdd vdd sg13_lv_pmos w=0.15u l=0.13u ng=1 m=1 mm_ok=1
XM2 OUT B vdd vdd sg13_lv_pmos w=0.15u l=0.13u ng=1 m=1 mm_ok=1
XM3 OUT A mid 0 sg13_lv_nmos w=0.15u l=0.13u ng=1 m=1 mm_ok=1
XM4 mid B 0 0 sg13_lv_nmos w=0.15u l=0.13u ng=1 m=1 mm_ok=1
VB B 0 PULSE(0 1.2 0 1n 1n 4n 10n)
VA A 0 PULSE(0 1.2 0 1n 1n 9n 20n)
VDD vdd 0 1.2
**** begin user architecture code

.lib cornerMOSlv.lib mos_tt

.tran 10p 100n
.save all

**** end user architecture code
**.ends
.end
