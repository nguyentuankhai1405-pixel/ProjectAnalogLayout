** sch_path: /foss/designs/TestAND.sch
**.subckt TestAND
Va Va GND PULSE(0 1.2 0 1n 1n 9n 20n)
VDD vdd GND 1.2
Vb Vb GND PULSE(0 1.2 0 1n 1n 4n 10n)
x1 vdd Va vout Vb GND AND2
**** begin user architecture code

.lib cornerMOSlv.lib mos_tt

.tran 10p 50n
.save all

.lib cornerMOSlv.lib mos_tt

.tran 10p 50n
.save all

**** end user architecture code
**.ends

* expanding   symbol:  /foss/designs/LogicGate/AND2.sym # of pins=5
** sym_path: /foss/designs/LogicGate/AND2.sym
** sch_path: /foss/designs/LogicGate/AND2.sch
.subckt AND2 VDD A Y B VSS
*.ipin A
*.ipin B
*.opin Y
*.iopin VDD
*.iopin VSS
XM2 net2 B VDD VDD sg13_lv_pmos w=0.15u l=0.13u ng=1 m=1 mm_ok=1
XM1 net2 A VDD VDD sg13_lv_pmos w=0.15u l=0.13u ng=1 m=1 mm_ok=1
XM3 net2 A net1 VSS sg13_lv_nmos w=0.15u l=0.13u ng=1 m=1 mm_ok=1
XM4 net1 B VSS VSS sg13_lv_nmos w=0.15u l=0.13u ng=1 m=1 mm_ok=1
XM5 Y net2 VSS VSS sg13_lv_nmos w=0.15u l=0.13u ng=1 m=1 mm_ok=1
XM6 Y net2 VDD VDD sg13_lv_pmos w=0.15u l=0.13u ng=1 m=1 mm_ok=1
.ends

.GLOBAL GND
.end
