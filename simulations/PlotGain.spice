** sch_path: /foss/designs/BaiTap1/PlotGain.sch
**.subckt PlotGain
XM1 vout vin GND GND sg13_lv_nmos w=10u l=0.5u ng=1 m=1 mm_ok=1
VDD VDD GND 1.2
VIN vin GND DC 0.4 AC 1
C1 vout GND 100f
XM2 vout vout VDD VDD sg13_lv_pmos w=10u l=1u ng=1 m=1 mm_ok=1
**** begin user architecture code

.op
.ac dec 50 1k 1G
.save all
.end

.lib cornerMOSlv.lib mos_tt

**** end user architecture code
**.ends
.GLOBAL GND
.end
