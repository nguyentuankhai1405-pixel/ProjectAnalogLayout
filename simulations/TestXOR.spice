** sch_path: /foss/designs/TestXOR.sch
**.subckt TestXOR
Va Va GND PULSE(0 1.2 0 1n 1n 9n 20n)
VDD vdd GND 1.2
Vb Vb GND PULSE(0 1.2 0 1n 1n 4n 10n)
x1 vdd Va vout Vb GND XOR2
**** begin user architecture code

.lib cornerMOSlv.lib mos_tt

.tran 10p 50n
.save all

**** end user architecture code
**.ends

* expanding   symbol:  /foss/designs/LogicGate/XOR2.sym # of pins=5
** sym_path: /foss/designs/LogicGate/XOR2.sym
** sch_path: /foss/designs/LogicGate/XOR2.sch
.subckt XOR2 VDD A Y B VSS
*.opin Y
*.iopin VSS
*.iopin VDD
*.ipin A
*.ipin B
XM1 net3 A' VDD VDD sg13_lv_pmos w=0.15u l=0.13u ng=1 m=1 mm_ok=1
XM2 Y B net3 VDD sg13_lv_pmos w=0.15u l=0.13u ng=1 m=1 mm_ok=1
XM3 net4 A VDD VDD sg13_lv_pmos w=0.15u l=0.13u ng=1 m=1 mm_ok=1
XM4 Y B' net4 VDD sg13_lv_pmos w=0.15u l=0.13u ng=1 m=1 mm_ok=1
XM5 Y A net1 VSS sg13_lv_nmos w=0.15u l=0.13u ng=1 m=1 mm_ok=1
XM6 net1 B VSS VSS sg13_lv_nmos w=0.15u l=0.13u ng=1 m=1 mm_ok=1
XM7 Y A' net2 VSS sg13_lv_nmos w=0.15u l=0.13u ng=1 m=1 mm_ok=1
XM8 net2 B' VSS VSS sg13_lv_nmos w=0.15u l=0.13u ng=1 m=1 mm_ok=1
x1 VDD A A' VSS inverter
x2 VDD B B' VSS inverter
.ends

* expanding   symbol:  /foss/designs/BTDay6-Ex/inverter.sym # of pins=4
** sym_path: /foss/designs/BTDay6-Ex/inverter.sym
** sch_path: /foss/designs/BTDay6-Ex/inverter.sch
.subckt inverter VDD A Y VSS
*.ipin A
*.opin Y
*.iopin VDD
*.iopin VSS
XM1 Y A VSS VSS sg13_lv_nmos w=0.15u l=0.13u ng=1 m=1 mm_ok=1
XM2 Y A VDD VDD sg13_lv_pmos w=0.15u l=0.13u ng=1 m=1 mm_ok=1
.ends

.GLOBAL GND
.end
