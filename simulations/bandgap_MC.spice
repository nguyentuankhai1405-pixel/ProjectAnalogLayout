** sch_path: /foss/designs/BTDay7-Ex/bandgap_MC.sch
**.subckt bandgap_MC v+ v- Vo1 VBG
*.iopin v+
*.iopin v-
*.iopin Vo1
*.opin VBG
XM8 GND v- net1 GND sg13_lv_nmos w=150n l=10u ng=1 m=1 mm_ok=1
XM6 net1 net1 vdd vdd sg13_lv_pmos w=1u l=1u ng=1 m=1 mm_ok=1
XM7 net2 net1 vdd vdd sg13_lv_pmos w=1u l=1u ng=1 m=1 mm_ok=1
XM9 v- net2 vdd vdd sg13_lv_pmos w=200n l=4u ng=1 m=1 mm_ok=1
I1 net4 GND 80u
V1 vdd GND DC 1.2
XM1 GND v+ v- GND sg13_lv_nmos w=7.14u l=5u ng=4 m=1 mm_ok=1
XM2 GND net3 net3 GND sg13_lv_nmos w=21u l=5u ng=8 m=1 mm_ok=1
XM3 v- Vo1 vdd vdd sg13_lv_pmos w=15u l=5u ng=8 m=1 mm_ok=1
XM4 v+ Vo1 vdd vdd sg13_lv_pmos w=15u l=5u ng=8 m=1 mm_ok=1
XM5 VBG Vo1 vdd vdd sg13_lv_pmos w=16u l=5u ng=8 m=1 mm_ok=1
XC3 VBG GND cap_cmim w=72.965e-6 l=72.965e-6 m=1 mm_ok=1
XR3 v+ net3 sub! rppd w=0.5e-6 l=194.345e-6 m=1 b=0 mm_ok=1
XR1 v+ GND sub! rppd w=0.5e-6 l=194.345e-6 m=1.2 b=0 mm_ok=1
XR2 VBG GND sub! rppd w=0.5e-6 l=192.395e-6 m=1 b=0 mm_ok=1
XC1 net2 GND cap_cmim w=18.195e-6 l=18.195e-6 m=1 mm_ok=1
XR4 GND sub! ptap1 R=0.09280542 w=100.78e-6 l=100.78e-6
x2 v- v+ GND vdd net4 Vo1 OTA
**** begin user architecture code

.control
let mc_runs = 200
let run = 1
set curplot = new
set scratch = $curplot

* Tu tao truc nhiet do chuan 31 diem tu -50 den 100 do C (khong bao gio bi loi)
compose temp_axis start=-50 stop=100 step=5

* Vong lap chay 200 lan
dowhile run <= mc_runs
    reset
    dc temp -50 100 5
    set run = $&run
    set dc = $curplot
    setplot $scratch
    let vbg_{$run} = {$dc}.v(VBG)
    setplot $dc
    let run = run + 1
end

* Ve toan bo 200 duong cong theo truc nhiet do
setplot $scratch
set nolegend
plot allv vs temp_axis title 'Monte Carlo 200 Runs: VBG vs Temperature'
write bandgap_testbench_mc_mis.raw allv temp_axis
.endc

.lib /foss/pdks/ihp-sg13g2/libs.tech/ngspice/models/cornerCAP.lib cap_typ
.lib /foss/pdks/ihp-sg13g2/libs.tech/ngspice/models/cornerRES.lib res_typ
.lib cornerMOSlv.lib mos_tt_mismatch

**** end user architecture code
**.ends

* expanding   symbol:  /foss/designs/BTDay7-Ex/OTA.sym # of pins=6
** sym_path: /foss/designs/BTDay7-Ex/OTA.sym
** sch_path: /foss/designs/BTDay7-Ex/OTA.sch
.subckt OTA V- V+ VSS VDD iout vout
*.iopin VDD
*.iopin iout
*.iopin V-
*.iopin VSS
*.iopin V+
*.iopin vout
XM6 iout iout VDD VDD sg13_lv_pmos w=75u l=2.08u ng=8 m=1 mm_ok=1
XM7 net1 iout VDD VDD sg13_lv_pmos w=5.3u l=1.95u ng=1 m=1 mm_ok=1
XM8 net3 V- net1 VDD sg13_lv_pmos w=7.41u l=3.64u ng=1 m=1 mm_ok=1
XM9 net2 V+ net1 VDD sg13_lv_pmos w=7.41u l=3.64u ng=1 m=1 mm_ok=1
XM10 net3 net3 VSS VSS sg13_lv_nmos w=720n l=9.75u ng=1 m=1 mm_ok=1
XM11 net2 net3 VSS VSS sg13_lv_nmos w=720n l=9.75u ng=1 m=1 mm_ok=1
XM1 vout net2 VSS VSS sg13_lv_nmos w=28.8u l=9.75u ng=4 m=1 mm_ok=1
XM2 vout iout VDD VDD sg13_lv_pmos w=75u l=2.08u ng=8 m=1 mm_ok=1
XC1 net2 vout cap_cmim w=22.295e-6 l=22.295e-6 m=1 mm_ok=1
.ends

.GLOBAL GND
.GLOBAL sub!
.end
