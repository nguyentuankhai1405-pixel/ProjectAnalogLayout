** sch_path: /foss/designs/pmos.sch
.subckt pmos d g s

vds 0 vds 1.2
vgs 0 vgs 1.2
M2 vds vgs 0 0 sg13_lv_pmos w=0.15u l=0.13u ng=1 m=1 mm_ok=1
**** begin user architecture code

.lib cornerMOSlv.lib mos_tt

.param temp =27
.control
save all
op
dc VDS 0 -1.2 -0.01 VGS 0 -1.2 -0.05
.endc

**** end user architecture code
.ends
