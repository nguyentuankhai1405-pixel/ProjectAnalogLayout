** sch_path: /foss/designs/BTDay1-Ex/Ex2_Lecture1.sch
.subckt Ex2_Lecture1

M1 vds vgs GND GND sg13_lv_nmos w=0.15u l=0.13u ng=1 m=1 mm_ok=1
VGS vgs GND 1.2
VDS vds GND 1.2
**** begin user architecture code

.lib cornerMOSlv.lib mos_tt

.param temp=27
.control
save all
op
dc VDS 0 1.2 0.01 VGS 0 1.2 0.05
.endc

**** end user architecture code
.ends
.GLOBAL GND
