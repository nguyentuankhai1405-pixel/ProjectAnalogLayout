** sch_path: /foss/designs/BTDay2-Ex/Ex1b_Lecture2.sch
**.subckt Ex1b_Lecture2
XM1 vout vin GND GND sg13_lv_nmos w=0.15u l=0.13u ng=1 m=1 mm_ok=1
XM2 vout vin vdd vdd sg13_lv_pmos w=0.15u l=0.13u ng=1 m=1 mm_ok=1
VDD vdd GND 1.2
E1 vin GND VOL=' '0.6+0.6*sin(time*2*pi*1e6)' '
**** begin user architecture code

.lib cornerMOSlv.lib mos_tt

.param temp=27
.control
save all
op
tran 1n 10u uic
.endc

**** end user architecture code
**.ends
.GLOBAL GND
.end
