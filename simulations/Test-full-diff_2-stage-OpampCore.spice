** sch_path: /foss/designs/BTDay5-Ex/Test-full-diff_2-stage-OpampCore.sch
**.subckt Test-full-diff_2-stage-OpampCore
VDD VDD VSS 1.2
VIN VIN VSS DC 0.8 Ac -0.5
VIP VIP VSS DC 0.8 Ac +0.5
VSS VSS GND 0
VB2 VBIAS VSS 0.65
x1 VBIAS VOUT VIP VIN VDD GND 2-stageOpampWithoutCMFB
**** begin user architecture code

.lib cornerMOSlv.lib mos_tt

.control
save all
op

* In ket qua cac nut chinh
echo ================= KET QUA DC =================
print v(vip) v(vin) v(vbias) v(vout)

* Chay mo phong AC do Gain va Phase Margin
ac dec 100 1 10G

let vid = v(vip) - v(vin)
let av = v(vout) / vid
let gain_db = db(av)
let phase_deg = cph(av) * 180 / pi

if phase_deg[0] > 90
  let phase_deg = phase_deg - 360
end

meas ac f_ug when gain_db=0 fall=1
meas ac phase_at_ug find phase_deg when gain_db=0 fall=1
let phase_margin = 180 + phase_at_ug

echo ================= PHASE MARGIN RESULT =================
print f_ug phase_at_ug phase_margin

let line_0db = 0 * frequency
let line_m180 = -180 + 0 * frequency

plot gain_db phase_deg line_0db line_m180 xlog ylimit -360 80 title Two-Stage

**** end user architecture code
**.ends

* expanding   symbol:  /foss/designs/BTDay5-Ex/2-stageOpampWithoutCMFB.sym # of pins=6
** sym_path: /foss/designs/BTDay5-Ex/2-stageOpampWithoutCMFB.sym
** sch_path: /foss/designs/BTDay5-Ex/2-stageOpampWithoutCMFB.sch
.subckt 2-stageOpampWithoutCMFB VBIAS VOUT VIP VIN VDD VSS
*.iopin VSS
*.iopin VDD
*.ipin VIP
*.ipin VIN
*.ipin VBIAS
*.opin VOUT
XM1 net3 VIN net1 VSS sg13_lv_nmos w=4u l=1u ng=1 m=2 mm_ok=1
XM2 net4 VIP net1 VSS sg13_lv_nmos w=4u l=1u ng=1 m=2 mm_ok=1
XM3 net1 net2 VSS VSS sg13_lv_nmos w=4u l=1u ng=1 m=4 mm_ok=1
XM4 net3 net3 VDD VDD sg13_lv_pmos w=4u l=1u ng=1 m=2 mm_ok=1
XM7 net2 net2 VSS VSS sg13_lv_nmos w=4u l=1u ng=1 m=1 mm_ok=1
XM8 net2 VBIAS VDD VDD sg13_lv_pmos w=1u l=6u ng=1 m=1 mm_ok=1
XM10 net4 net3 VDD VDD sg13_lv_pmos w=4u l=1u ng=1 m=2 mm_ok=1
XM5 VOUT net2 VSS VSS sg13_lv_nmos w=4u l=1u ng=1 m=5 mm_ok=1
XM11 VOUT net4 VDD VDD sg13_lv_pmos w=4u l=1u ng=1 m=5 mm_ok=1
C2 VOUT net5 0.4p
R1 net5 net4 150k
.ends

.GLOBAL GND
.end
