** sch_path: /foss/designs/Inverter_Test3.sch
**.subckt Inverter_Test3
vdd1 net4 net5 1.2
vin net6 0 PULSE(0 1.2 0 1n 1n 4n 10n)
x2 net7 net8 net9 net10 Inverter3
**** begin user architecture code

.lib cornerMOSlv.lib mos_tt

.tran 10p 100n
.save all

**** end user architecture code
**.ends

* expanding   symbol:  Inverter3.sym # of pins=4
** sym_path: /foss/designs/Inverter3.sym
** sch_path: /foss/designs/Inverter3.sch
.subckt Inverter3 VDD A Y VSS
*.ipin A
*.iopin VSS
*.iopin VDD
*.opin Y
XM2 Y A VSS VSS sg13_lv_nmos w=0.15u l=0.13u ng=1 m=1 mm_ok=1
XM1 Y A VDD VDD sg13_lv_pmos w=0.15u l=0.13u ng=1 m=1 mm_ok=1
.ends

.end
