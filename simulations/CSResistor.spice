** sch_path: /foss/designs/BaiTap1/CSResistor.sch
**.subckt CSResistor
XM1 vout vin GND GND sg13_lv_nmos w=3u l=0.5u ng=1 m=1 mm_ok=1
VDD VDD GND 1.2
VIN vin GND DC 0.45 AC 1
R1 VDD vout 20k
C1 vout GND 100f
**** begin user architecture code

.op
.ac dec 50 1k 1G
.save all
.end

.lib cornerMOSlv.lib mos_tt

**** end user architecture code
**.ends
.GLOBAL GND
.end
