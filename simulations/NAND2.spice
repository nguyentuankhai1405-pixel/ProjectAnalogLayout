** sch_path: /foss/designs/LogicGate/NAND2.sch
**.subckt NAND2 VDD A Y B VSS
*.opin Y
*.iopin VDD
*.iopin VSS
*.ipin A
*.ipin B
XXM2 Y B VDD VDD sg13_lv_pmos w=0.15u l=0.13u ng=1 m=1 mm_ok=1
XXM1 Y A VDD VDD sg13_lv_pmos w=0.15u l=0.13u ng=1 m=1 mm_ok=1
XXM3 Y A net1 VSS sg13_lv_nmos w=0.15u l=0.13u ng=1 m=1 mm_ok=1
XXM4 net1 B VSS VSS sg13_lv_nmos w=0.15u l=0.13u ng=1 m=1 mm_ok=1
**.ends
.end
