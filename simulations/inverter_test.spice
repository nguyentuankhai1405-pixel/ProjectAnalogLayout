** sch_path: /foss/designs/inverter_test.sch
**.subckt inverter_test
vdd1 VDD 0 1.2
vin VIN 0 PULSE(0 1.2 0 1n 1n 4n 10n)
x1 net1 net2 net3 Inverter2
**** begin user architecture code

.lib cornerMOSlv.lib mos_tt

.tran 10p 100n
.save all

**** end user architecture code
**.ends

* expanding   symbol:  Inverter2.sym # of pins=4
** sym_path: /foss/designs/Inverter2.sym
** sch_path: /foss/designs/Inverter2.sch
.subckt Inverter2 name=VDD  Y
*.ipin A
*.iopin VSS
*.iopin VDD
*.opin Y
XM2 Y A VSS VSS sg13_lv_nmos w=0.15u l=0.13u ng=1 m=1 mm_ok=1
XM1 Y A VDD VDD sg13_lv_pmos w=0.15u l=0.13u ng=1 m=1 mm_ok=1
.ends

.end
