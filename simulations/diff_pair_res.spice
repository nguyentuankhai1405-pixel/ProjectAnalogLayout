** sch_path: /foss/designs/BTDay4-Ex/diff_pair_res.sch
**.subckt diff_pair_res VON VOP VIN VIP VB VDD VSS
*.iopin VDD
*.iopin VSS
*.opin VOP
*.opin VON
*.ipin VIP
*.ipin VB
*.ipin VIN
XM1 VON VIP net1 VSS sg13_lv_nmos w=5u l=1u ng=1 m=1 mm_ok=1
XM2 VOP VIN net1 VSS sg13_lv_nmos w=5u l=1u ng=1 m=1 mm_ok=1
XM3 net1 VB VSS VSS sg13_lv_nmos w=5u l=0.35u ng=1 m=1 mm_ok=1
R1 VDD VON 50k
R2 VDD VOP 50k
**** begin user architecture code

.lib cornerMOSlv.lib mos_tt

.control
op
print von vop
print v(vop)-v(von)

ac dec 100 1 10G
let av_diff = v(vop) - v(von)
plot db(av_diff) title Differential

**** end user architecture code
**.ends
.end
