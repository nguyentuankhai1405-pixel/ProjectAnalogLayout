** sch_path: /foss/designs/nmos_tb.sch
**.subckt nmos_tb
XM1 vds vgs 0 0 sg13_lv_nmos w=0.15u l=0.13u ng=1 m=1 mm_ok=1
vds vds 0 1.2
VGS vgs 0 1.2
**** begin user architecture code

.lib cornerMOSlv.lib mos_tt

.param temp =27
.control
save all
op
dc VDS 0 1.2 0.01 VGS 0 1.2 0.05
.endc

**** end user architecture code
**.ends
.end
