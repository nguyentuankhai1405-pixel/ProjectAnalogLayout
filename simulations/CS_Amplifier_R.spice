** sch_path: /foss/designs/BaiTap1/CS_Amplifier_R.sch
**.subckt CS_Amplifier_R VDD OUT IN VSS
*.ipin IN
*.iopin VSS
*.iopin VDD
*.opin OUT
XM1 OUT IN VSS VSS sg13_lv_nmos w=3u l=0.5u ng=1 m=1 mm_ok=1
R1 VDD OUT 20k
**** begin user architecture code

.lib cornerMOSlv.lib mos_tt

**** end user architecture code
**.ends
.end
