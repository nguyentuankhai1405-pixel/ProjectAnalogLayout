** sch_path: /foss/designs/LogicGate/OR2.sch
**.subckt OR2 VDD A Y B VSS
*.ipin A
*.ipin B
*.opin Y
*.iopin VDD
*.iopin VSS
XM5 Y net1 VSS VSS sg13_lv_nmos w=0.15u l=0.13u ng=1 m=1 mm_ok=1
XM6 Y net1 VDD VDD sg13_lv_pmos w=0.15u l=0.13u ng=1 m=1 mm_ok=1
XM1 net2 A VDD VDD sg13_lv_pmos w=0.15u l=0.13u ng=1 m=1 mm_ok=1
XM2 net1 B net2 VDD sg13_lv_pmos w=0.15u l=0.13u ng=1 m=1 mm_ok=1
XM3 net1 A VSS VSS sg13_lv_nmos w=0.15u l=0.13u ng=1 m=1 mm_ok=1
XM4 net1 B VSS VSS sg13_lv_nmos w=0.15u l=0.13u ng=1 m=1 mm_ok=1
**.ends
.end
