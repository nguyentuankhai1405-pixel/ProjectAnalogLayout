** sch_path: /home/vietha/pdk/IHP-Open-PDK/ihp-sg13g2/libs.tech/inverter.sch
.subckt inverter A Y VDD VSS
*.PININFO A:I Y:O VDD:B VSS:B
MM1 Y A VSS VSS sg13_lv_nmos w=0.15u l=0.13u ng=1 m=1
MM2 Y A VDD VDD sg13_lv_pmos w=0.15u l=0.13u ng=1 m=1
.ends
.end
