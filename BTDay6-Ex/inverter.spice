* NGSPICE file created from inverter.ext - technology: ihp-sg13g2

.subckt nmos a_100_15# a_74_n21# SUB a_0_0#
X0 a_100_15# a_74_n21# a_0_0# SUB sg13_lv_nmos ad=0.1005p pd=1.34u as=0.1005p ps=1.34u w=0.15u l=0.13u
C0 a_0_0# a_74_n21# 0.00188f
C1 a_100_15# a_74_n21# 0.00188f
C2 a_0_0# a_100_15# 0.01201f
C3 a_100_15# SUB 0.04751f
C4 a_0_0# SUB 0.04751f
.ends

.subckt pmos a_100_15# w_n62_n62# a_74_n21# SUB a_0_0#
X0 a_100_15# a_74_n21# a_0_0# w_n62_n62# sg13_lv_pmos ad=0.1005p pd=1.34u as=0.1005p ps=1.34u w=0.15u l=0.13u
C0 w_n62_n62# a_0_0# 0.00467f
C1 a_100_15# a_0_0# 0.01201f
C2 a_74_n21# a_0_0# 0.00188f
C3 w_n62_n62# a_100_15# 0.00467f
C4 w_n62_n62# a_74_n21# 0.02613f
C5 a_74_n21# a_100_15# 0.00188f
C6 a_100_15# SUB 0.03108f
C7 a_0_0# SUB 0.03108f
.ends

.subckt inverter VDD A VSS Y
Xnmos_0 Y A VSS VSS nmos
Xpmos_0 Y VDD A VSS VDD pmos
C0 Y A 0.02961f
C1 VDD A 0.04494f
C2 VDD Y 0.02061f
C3 Y VSS 0.04617f
C4 A VSS 0.11055f
C5 VDD VSS 0.09676f
.ends
